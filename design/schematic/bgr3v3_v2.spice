** sch_path: /home/ttuser/TT_WORK/rel/bgr3v3_v2.sch
**.subckt bgr3v3_v2 VDD GND Vref Vptat IN30U_0 IN30U_1
*.ipin VDD
*.ipin GND
*.opin Vref
*.opin Vptat
*.opin IN30U_0
*.opin IN30U_1
XQA GND GND vaa sky130_fd_pr__pnp_05v5_W3p40L3p40 m=1
XQB0 GND GND net1 sky130_fd_pr__pnp_05v5_W3p40L3p40 m=3
XRB net1 vbb GND sky130_fd_pr__res_xhigh_po_0p35 L=1 mult=1 m=1
XRef6 net2 net9 GND sky130_fd_pr__res_xhigh_po_0p35 L=1 mult=1 m=1
XQREF GND GND net2 sky130_fd_pr__pnp_05v5_W3p40L3p40 m=1
XqC1 GND VDD sky130_fd_pr__cap_mim_m3_1 W=30 L=30 MF=1 m=1
XRstart0 net10 vstart GND sky130_fd_pr__res_xhigh_po_0p35 L=1 mult=1 m=1
XRref5 net9 net11 GND sky130_fd_pr__res_xhigh_po_0p35 L=1 mult=1 m=1
XRref4 net11 net12 GND sky130_fd_pr__res_xhigh_po_0p35 L=1 mult=1 m=1
XRref3 net12 net13 GND sky130_fd_pr__res_xhigh_po_0p35 L=1 mult=1 m=1
XRref2 net13 net14 GND sky130_fd_pr__res_xhigh_po_0p35 L=1 mult=1 m=1
XRref1 net14 net15 GND sky130_fd_pr__res_xhigh_po_0p35 L=1 mult=1 m=1
XRref0 net15 Vref GND sky130_fd_pr__res_xhigh_po_0p35 L=1 mult=1 m=1
XRptat1 net16 net17 GND sky130_fd_pr__res_xhigh_po_0p35 L=1 mult=1 m=1
XRptat0 net17 Vptat GND sky130_fd_pr__res_xhigh_po_0p35 L=1 mult=1 m=1
XRstart1 net18 net10 GND sky130_fd_pr__res_xhigh_po_0p35 L=1 mult=1 m=1
XRstart2 net19 net18 GND sky130_fd_pr__res_xhigh_po_0p35 L=1 mult=1 m=1
XRstart3 net20 net19 GND sky130_fd_pr__res_xhigh_po_0p35 L=1 mult=1 m=1
XRstart4 net21 net20 GND sky130_fd_pr__res_xhigh_po_0p35 L=1 mult=1 m=1
XRstart5 net22 net21 GND sky130_fd_pr__res_xhigh_po_0p35 L=1 mult=1 m=1
XRstart6 net23 net22 GND sky130_fd_pr__res_xhigh_po_0p35 L=1 mult=1 m=1
XRstart7 net3 net23 GND sky130_fd_pr__res_xhigh_po_0p35 L=1 mult=1 m=1
XQB1 GND GND net1 sky130_fd_pr__pnp_05v5_W3p40L3p40 m=3
XQB2 GND GND net1 sky130_fd_pr__pnp_05v5_W3p40L3p40 m=1
XQB3 GND GND net1 sky130_fd_pr__pnp_05v5_W3p40L3p40 m=1
XQDMY0 GND GND GND sky130_fd_pr__pnp_05v5_W3p40L3p40 m=1
XQDMY1 GND GND GND sky130_fd_pr__pnp_05v5_W3p40L3p40 m=1
XRptat2 net24 net16 GND sky130_fd_pr__res_xhigh_po_0p35 L=1 mult=1 m=1
XRstart8 net3 net25 GND sky130_fd_pr__res_xhigh_po_0p35 L=1 mult=1 m=1
XRstart9 net25 net26 GND sky130_fd_pr__res_xhigh_po_0p35 L=1 mult=1 m=1
XRstart10 net26 net27 GND sky130_fd_pr__res_xhigh_po_0p35 L=1 mult=1 m=1
XRstart11 net27 GND GND sky130_fd_pr__res_xhigh_po_0p35 L=1 mult=1 m=1
XMPREF Vref pgate VDD VDD sky130_fd_pr__pfet_g5v0d10v5 L=1 W=8 nf=1 ad='int((nf+1)/2) * W/nf * 0.29' as='int((nf+2)/2) * W/nf * 0.29'
+ pd='2*int((nf+1)/2) * (W/nf + 0.29)' ps='2*int((nf+2)/2) * (W/nf + 0.29)' nrd='0.29 / W' nrs='0.29 / W' sa=0 sb=0 sd=0 mult=1 m=1
XMPB pgate pgate VDD VDD sky130_fd_pr__pfet_g5v0d10v5 L=1 W=8 nf=1 ad='int((nf+1)/2) * W/nf * 0.29' as='int((nf+2)/2) * W/nf * 0.29'
+ pd='2*int((nf+1)/2) * (W/nf + 0.29)' ps='2*int((nf+2)/2) * (W/nf + 0.29)' nrd='0.29 / W' nrs='0.29 / W' sa=0 sb=0 sd=0 mult=1 m=1
XMPA ngate pgate VDD VDD sky130_fd_pr__pfet_g5v0d10v5 L=1 W=8 nf=1 ad='int((nf+1)/2) * W/nf * 0.29' as='int((nf+2)/2) * W/nf * 0.29'
+ pd='2*int((nf+1)/2) * (W/nf + 0.29)' ps='2*int((nf+2)/2) * (W/nf + 0.29)' nrd='0.29 / W' nrs='0.29 / W' sa=0 sb=0 sd=0 mult=1 m=1
XMPPTAT0 Vptat pgate VDD VDD sky130_fd_pr__pfet_g5v0d10v5 L=1 W=8 nf=1 ad='int((nf+1)/2) * W/nf * 0.29' as='int((nf+2)/2) * W/nf * 0.29'
+ pd='2*int((nf+1)/2) * (W/nf + 0.29)' ps='2*int((nf+2)/2) * (W/nf + 0.29)' nrd='0.29 / W' nrs='0.29 / W' sa=0 sb=0 sd=0 mult=1 m=1
XMNB pgate ngate vbb GND sky130_fd_pr__nfet_g5v0d10v5 L=2 W=8 nf=1 ad='int((nf+1)/2) * W/nf * 0.29' as='int((nf+2)/2) * W/nf * 0.29'
+ pd='2*int((nf+1)/2) * (W/nf + 0.29)' ps='2*int((nf+2)/2) * (W/nf + 0.29)' nrd='0.29 / W' nrs='0.29 / W' sa=0 sb=0 sd=0 mult=1 m=1
XMNA ngate ngate vaa GND sky130_fd_pr__nfet_g5v0d10v5 L=2 W=8 nf=1 ad='int((nf+1)/2) * W/nf * 0.29' as='int((nf+2)/2) * W/nf * 0.29'
+ pd='2*int((nf+1)/2) * (W/nf + 0.29)' ps='2*int((nf+2)/2) * (W/nf + 0.29)' nrd='0.29 / W' nrs='0.29 / W' sa=0 sb=0 sd=0 mult=1 m=1
XMNSTASW pgate vstart2 GND GND sky130_fd_pr__nfet_g5v0d10v5 L=2 W=1 nf=1 ad='int((nf+1)/2) * W/nf * 0.29' as='int((nf+2)/2) * W/nf * 0.29'
+ pd='2*int((nf+1)/2) * (W/nf + 0.29)' ps='2*int((nf+2)/2) * (W/nf + 0.29)' nrd='0.29 / W' nrs='0.29 / W' sa=0 sb=0 sd=0 mult=1 m=1
XMNSTAINV vstart2 vstart GND GND sky130_fd_pr__nfet_g5v0d10v5 L=1 W=8 nf=1 ad='int((nf+1)/2) * W/nf * 0.29' as='int((nf+2)/2) * W/nf * 0.29'
+ pd='2*int((nf+1)/2) * (W/nf + 0.29)' ps='2*int((nf+2)/2) * (W/nf + 0.29)' nrd='0.29 / W' nrs='0.29 / W' sa=0 sb=0 sd=0 mult=2 m=2
XMPSTAINV vstart2 vstart VDD VDD sky130_fd_pr__pfet_g5v0d10v5 L=2 W=1 nf=1 ad='int((nf+1)/2) * W/nf * 0.29' as='int((nf+2)/2) * W/nf * 0.29'
+ pd='2*int((nf+1)/2) * (W/nf + 0.29)' ps='2*int((nf+2)/2) * (W/nf + 0.29)' nrd='0.29 / W' nrs='0.29 / W' sa=0 sb=0 sd=0 mult=1 m=1
XR30U GND Vbinm GND sky130_fd_pr__res_xhigh_po_0p35 L=11 mult=1 m=1
XMN30U net4 Vbio Vbinm GND sky130_fd_pr__nfet_g5v0d10v5 L=2 W=8 nf=1 ad='int((nf+1)/2) * W/nf * 0.29' as='int((nf+2)/2) * W/nf * 0.29'
+ pd='2*int((nf+1)/2) * (W/nf + 0.29)' ps='2*int((nf+2)/2) * (W/nf + 0.29)' nrd='0.29 / W' nrs='0.29 / W' sa=0 sb=0 sd=0 mult=1 m=1
XMN30U_0 net7 net7 GND GND sky130_fd_pr__nfet_g5v0d10v5 L=2 W=8 nf=1 ad='int((nf+1)/2) * W/nf * 0.29' as='int((nf+2)/2) * W/nf * 0.29'
+ pd='2*int((nf+1)/2) * (W/nf + 0.29)' ps='2*int((nf+2)/2) * (W/nf + 0.29)' nrd='0.29 / W' nrs='0.29 / W' sa=0 sb=0 sd=0 mult=1 m=1
XMNOPM Vbio net5 GND GND sky130_fd_pr__nfet_g5v0d10v5 L=1 W=8 nf=1 ad='int((nf+1)/2) * W/nf * 0.29' as='int((nf+2)/2) * W/nf * 0.29'
+ pd='2*int((nf+1)/2) * (W/nf + 0.29)' ps='2*int((nf+2)/2) * (W/nf + 0.29)' nrd='0.29 / W' nrs='0.29 / W' sa=0 sb=0 sd=0 mult=1 m=1
XMNOPP net5 net5 GND GND sky130_fd_pr__nfet_g5v0d10v5 L=1 W=8 nf=1 ad='int((nf+1)/2) * W/nf * 0.29' as='int((nf+2)/2) * W/nf * 0.29'
+ pd='2*int((nf+1)/2) * (W/nf + 0.29)' ps='2*int((nf+2)/2) * (W/nf + 0.29)' nrd='0.29 / W' nrs='0.29 / W' sa=0 sb=0 sd=0 mult=1 m=1
XMPOPINP net5 Vref net6 VDD sky130_fd_pr__pfet_g5v0d10v5 L=1 W=8 nf=1 ad='int((nf+1)/2) * W/nf * 0.29' as='int((nf+2)/2) * W/nf * 0.29'
+ pd='2*int((nf+1)/2) * (W/nf + 0.29)' ps='2*int((nf+2)/2) * (W/nf + 0.29)' nrd='0.29 / W' nrs='0.29 / W' sa=0 sb=0 sd=0 mult=1 m=1
XMPOPINM Vbio Vbinm net6 VDD sky130_fd_pr__pfet_g5v0d10v5 L=1 W=8 nf=1 ad='int((nf+1)/2) * W/nf * 0.29' as='int((nf+2)/2) * W/nf * 0.29'
+ pd='2*int((nf+1)/2) * (W/nf + 0.29)' ps='2*int((nf+2)/2) * (W/nf + 0.29)' nrd='0.29 / W' nrs='0.29 / W' sa=0 sb=0 sd=0 mult=1 m=1
XMPOPC net6 net8 VDD VDD sky130_fd_pr__pfet_g5v0d10v5 L=2 W=2 nf=1 ad='int((nf+1)/2) * W/nf * 0.29' as='int((nf+2)/2) * W/nf * 0.29'
+ pd='2*int((nf+1)/2) * (W/nf + 0.29)' ps='2*int((nf+2)/2) * (W/nf + 0.29)' nrd='0.29 / W' nrs='0.29 / W' sa=0 sb=0 sd=0 mult=1 m=1
XMPSTA0 vstart pgate VDD VDD sky130_fd_pr__pfet_g5v0d10v5 L=1 W=8 nf=1 ad='int((nf+1)/2) * W/nf * 0.29' as='int((nf+2)/2) * W/nf * 0.29'
+ pd='2*int((nf+1)/2) * (W/nf + 0.29)' ps='2*int((nf+2)/2) * (W/nf + 0.29)' nrd='0.29 / W' nrs='0.29 / W' sa=0 sb=0 sd=0 mult=1 m=1
XRptat3 GND net24 GND sky130_fd_pr__res_xhigh_po_0p35 L=1 mult=1 m=1
XMPPTAT1 Vptat pgate VDD VDD sky130_fd_pr__pfet_g5v0d10v5 L=1 W=8 nf=1 ad='int((nf+1)/2) * W/nf * 0.29' as='int((nf+2)/2) * W/nf * 0.29'
+ pd='2*int((nf+1)/2) * (W/nf + 0.29)' ps='2*int((nf+2)/2) * (W/nf + 0.29)' nrd='0.29 / W' nrs='0.29 / W' sa=0 sb=0 sd=0 mult=1 m=1
XMPPTAT2 Vptat pgate VDD VDD sky130_fd_pr__pfet_g5v0d10v5 L=1 W=8 nf=1 ad='int((nf+1)/2) * W/nf * 0.29' as='int((nf+2)/2) * W/nf * 0.29'
+ pd='2*int((nf+1)/2) * (W/nf + 0.29)' ps='2*int((nf+2)/2) * (W/nf + 0.29)' nrd='0.29 / W' nrs='0.29 / W' sa=0 sb=0 sd=0 mult=1 m=1
XMPPTAT3 Vptat pgate VDD VDD sky130_fd_pr__pfet_g5v0d10v5 L=1 W=8 nf=1 ad='int((nf+1)/2) * W/nf * 0.29' as='int((nf+2)/2) * W/nf * 0.29'
+ pd='2*int((nf+1)/2) * (W/nf + 0.29)' ps='2*int((nf+2)/2) * (W/nf + 0.29)' nrd='0.29 / W' nrs='0.29 / W' sa=0 sb=0 sd=0 mult=1 m=1
XMPPTAT4 Vptat pgate VDD VDD sky130_fd_pr__pfet_g5v0d10v5 L=1 W=8 nf=1 ad='int((nf+1)/2) * W/nf * 0.29' as='int((nf+2)/2) * W/nf * 0.29'
+ pd='2*int((nf+1)/2) * (W/nf + 0.29)' ps='2*int((nf+2)/2) * (W/nf + 0.29)' nrd='0.29 / W' nrs='0.29 / W' sa=0 sb=0 sd=0 mult=1 m=1
XMPSTA1 vstart pgate VDD VDD sky130_fd_pr__pfet_g5v0d10v5 L=1 W=8 nf=1 ad='int((nf+1)/2) * W/nf * 0.29' as='int((nf+2)/2) * W/nf * 0.29'
+ pd='2*int((nf+1)/2) * (W/nf + 0.29)' ps='2*int((nf+2)/2) * (W/nf + 0.29)' nrd='0.29 / W' nrs='0.29 / W' sa=0 sb=0 sd=0 mult=1 m=1
XMPSTA2 vstart pgate VDD VDD sky130_fd_pr__pfet_g5v0d10v5 L=1 W=8 nf=1 ad='int((nf+1)/2) * W/nf * 0.29' as='int((nf+2)/2) * W/nf * 0.29'
+ pd='2*int((nf+1)/2) * (W/nf + 0.29)' ps='2*int((nf+2)/2) * (W/nf + 0.29)' nrd='0.29 / W' nrs='0.29 / W' sa=0 sb=0 sd=0 mult=1 m=1
XMPSTA3 vstart pgate VDD VDD sky130_fd_pr__pfet_g5v0d10v5 L=1 W=8 nf=1 ad='int((nf+1)/2) * W/nf * 0.29' as='int((nf+2)/2) * W/nf * 0.29'
+ pd='2*int((nf+1)/2) * (W/nf + 0.29)' ps='2*int((nf+2)/2) * (W/nf + 0.29)' nrd='0.29 / W' nrs='0.29 / W' sa=0 sb=0 sd=0 mult=1 m=1
XMN30U_1 IN30U_0 net7 GND GND sky130_fd_pr__nfet_g5v0d10v5 L=2 W=8 nf=1 ad='int((nf+1)/2) * W/nf * 0.29' as='int((nf+2)/2) * W/nf * 0.29'
+ pd='2*int((nf+1)/2) * (W/nf + 0.29)' ps='2*int((nf+2)/2) * (W/nf + 0.29)' nrd='0.29 / W' nrs='0.29 / W' sa=0 sb=0 sd=0 mult=1 m=1
XMN30U_2 IN30U_1 net7 GND GND sky130_fd_pr__nfet_g5v0d10v5 L=2 W=8 nf=1 ad='int((nf+1)/2) * W/nf * 0.29' as='int((nf+2)/2) * W/nf * 0.29'
+ pd='2*int((nf+1)/2) * (W/nf + 0.29)' ps='2*int((nf+2)/2) * (W/nf + 0.29)' nrd='0.29 / W' nrs='0.29 / W' sa=0 sb=0 sd=0 mult=1 m=1
XQDMY2 GND GND GND sky130_fd_pr__pnp_05v5_W3p40L3p40 m=6
XQDMY3 GND GND GND sky130_fd_pr__pnp_05v5_W3p40L3p40 m=6
XQDMY4 GND GND GND sky130_fd_pr__pnp_05v5_W3p40L3p40 m=3
XQDMY5 GND GND GND sky130_fd_pr__pnp_05v5_W3p40L3p40 m=3
XMNOPDMY GND GND GND GND sky130_fd_pr__nfet_g5v0d10v5 L=1 W=8 nf=1 ad='int((nf+1)/2) * W/nf * 0.29' as='int((nf+2)/2) * W/nf * 0.29'
+ pd='2*int((nf+1)/2) * (W/nf + 0.29)' ps='2*int((nf+2)/2) * (W/nf + 0.29)' nrd='0.29 / W' nrs='0.29 / W' sa=0 sb=0 sd=0 mult=1 m=1
XRDMY0 GND GND GND sky130_fd_pr__res_xhigh_po_0p35 L=1 mult=1 m=1
XRDMY1 GND GND GND sky130_fd_pr__res_xhigh_po_0p35 L=1 mult=1 m=1
XRDMY2 GND GND GND sky130_fd_pr__res_xhigh_po_0p35 L=1 mult=1 m=1
XRDMY3 GND GND GND sky130_fd_pr__res_xhigh_po_0p35 L=1 mult=1 m=1
XRDMY4 GND GND GND sky130_fd_pr__res_xhigh_po_0p35 L=1 mult=1 m=1
XRDMY5 GND GND GND sky130_fd_pr__res_xhigh_po_0p35 L=1 mult=1 m=1
XRDMY6 GND GND GND sky130_fd_pr__res_xhigh_po_0p35 L=1 mult=1 m=1
XRDMY7 GND GND GND sky130_fd_pr__res_xhigh_po_0p35 L=1 mult=1 m=1
XRDMY8 GND GND GND sky130_fd_pr__res_xhigh_po_0p35 L=1 mult=1 m=1
XR30UDMY0 GND GND GND sky130_fd_pr__res_xhigh_po_0p35 L=11 mult=1 m=1
XR30UDMY1 GND GND GND sky130_fd_pr__res_xhigh_po_0p35 L=11 mult=1 m=1
XRTIEL GND net8 GND sky130_fd_pr__res_xhigh_po_0p35 L=1 mult=1 m=1
XRDMY10 GND GND GND sky130_fd_pr__res_xhigh_po_0p35 L=1 mult=1 m=1
XRDMY11 GND GND GND sky130_fd_pr__res_xhigh_po_0p35 L=1 mult=1 m=1
XMPIB0 net4 net4 VDD VDD sky130_fd_pr__pfet_g5v0d10v5 L=1 W=8 nf=1 ad='int((nf+1)/2) * W/nf * 0.29' as='int((nf+2)/2) * W/nf * 0.29'
+ pd='2*int((nf+1)/2) * (W/nf + 0.29)' ps='2*int((nf+2)/2) * (W/nf + 0.29)' nrd='0.29 / W' nrs='0.29 / W' sa=0 sb=0 sd=0 mult=1 m=1
XMPIB1 net7 net4 VDD VDD sky130_fd_pr__pfet_g5v0d10v5 L=1 W=8 nf=1 ad='int((nf+1)/2) * W/nf * 0.29' as='int((nf+2)/2) * W/nf * 0.29'
+ pd='2*int((nf+1)/2) * (W/nf + 0.29)' ps='2*int((nf+2)/2) * (W/nf + 0.29)' nrd='0.29 / W' nrs='0.29 / W' sa=0 sb=0 sd=0 mult=1 m=1
XMPIB2 VDD VDD VDD VDD sky130_fd_pr__pfet_g5v0d10v5 L=1 W=8 nf=1 ad='int((nf+1)/2) * W/nf * 0.29' as='int((nf+2)/2) * W/nf * 0.29'
+ pd='2*int((nf+1)/2) * (W/nf + 0.29)' ps='2*int((nf+2)/2) * (W/nf + 0.29)' nrd='0.29 / W' nrs='0.29 / W' sa=0 sb=0 sd=0 mult=1 m=1
**.ends
.end
